* Characterization Deck for sky130_sricharan_inv
.lib 'sky130.lib.spice' tt
.include 'sky130_sricharan_inv.spice'

* Inverter instance: A VGND VNB VPB VPWR Y
X1 in 0 0 vdd vdd out sky130_sricharan_inv

Vdd vdd 0 1.8V
Vin in 0 pulse(0V 1.8V 0.5ns 0.05ns 0.05ns 1.5ns 3ns)
Cload out 0 20fF

.tran 0.001ns 4ns

.control
run

* Delay measurements (50% to 50%)
meas tran t_fall_in  WHEN v(in)=0.9 FALL=1
meas tran t_rise_out WHEN v(out)=0.9 RISE=1
meas tran t_rise_in  WHEN v(in)=0.9 RISE=1
meas tran t_fall_out WHEN v(out)=0.9 FALL=1

let t_pdr = t_rise_out - t_fall_in
let t_pdf = t_fall_out - t_rise_in

* Transition Slew measurements (10% = 0.18V, 90% = 1.62V)
meas tran t_out_10 WHEN v(out)=0.18 RISE=1
meas tran t_out_90 WHEN v(out)=1.62 RISE=1
meas tran t_out_fall_90 WHEN v(out)=1.62 FALL=1
meas tran t_out_fall_10 WHEN v(out)=0.18 FALL=1

let t_rise_slew = t_out_90 - t_out_10
let t_fall_slew = t_out_fall_10 - t_out_fall_90

print t_pdr t_pdf t_rise_slew t_fall_slew

plot v(in) v(out)
.endc
.end
